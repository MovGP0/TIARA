|   IBIS Model for C6748ZCE
[IBIS Ver]   3.2
[Comment Char]  |_char
[File Name]   c6748_zce.ibs
[File Rev]   1.0
[Date]   March 8, 2013
[Source]   From Optimal Corporation's PakSi-E result.
[Notes]   Created from Freon_16x16_OSV_12172008_H_1.mcm
|   (1) C6748 ZCE contains dual rail I/O buffers that
|   are capable of running are two different core
|   voltages depedent on the schematic hookup
|   (a) 1.8V
|   (b) 3.3V
|   (2) Specific Model Sections/Name Decoders are determined
|   based upon the value that is supplied to the
|   particular I/O buffer as well as any pull up/down
|   resistors that are selected. Refer to the Model Selecter
|   Definitions for details regarding model selection at
|   1.8V rail or the 3.3V rail.
[Disclaimer]
|   Please be aware that in the absence of a written agreement
|   Texas Instruments (TI) assumes no liability for:
|   (1) The accuracy of the IBIS models provided to your company
|   (2) The proper functioning of these Models in your design
|   or for any resulting applications;or
|   (3) Infringement of patents,copyrights, or intellectual
|   property rights resulting from your use of these models.
|   TI provides IBIS Models as a service to our customers and
|   therefore reserves the right to limit distribution of the
|   Models.
[Copyright] Copyright 2011, Texas Instruments Incorporated. All Rights Reserved
[Component]   C6748ZCE
[Manufacturer]   Texas Instruments
[Package]
| variable   typ   min   max
R_pkg   4.15668e-001  2.28452e-002  6.49659e-001
L_pkg   3.30265e-009  8.15850e-011  6.01630e-009
C_pkg   7.30249e-013  5.00661e-013  1.13139e-012
| Note - some signal_names were truncated to meet the 80 character
|  per line limit of IBIS spec v3.2
[Pin] signal_name  model_name R_pin   L_pin   C_pin
A1   ACLKR_GP015  BC1833DV40CTPBFZ 5.91871e-001 5.89640e-009 8.85863e-013
B1   ACLKX_GP014  BC1833DV40CTPBFZ 4.86257e-001 5.42480e-009 8.43455e-013
C2   AFSR0_GP013  BC1833DV40CTPBFZ 4.95087e-001 4.50480e-009 8.94184e-013
B2   AFSX0_GP012  BC1833DV40CTPBFZ 5.24155e-001 4.89370e-009 9.02440e-013
A2   AHCLKR   BC1833DV40CTPBFZ 5.57738e-001 5.17010e-009 9.36823e-013
A3   AHCLKX   BC1833DV40CTPBFZ 6.49659e-001 6.01630e-009 1.04360e-012
D5   AMUTE   BC1833DV40CTPBFZ 5.05628e-001 3.54900e-009 1.13139e-012
F4   AMUTEIN   BC1833DV40CTPBFZ 2.70359e-001 2.09390e-009 8.60715e-013
F3   AXR00   BC1833DV40CTPBFZ 5.87268e-001 5.04320e-009 8.85130e-013
E1   AXR01   BC1833DV40CTPBFZ 5.06257e-001 4.56730e-009 7.02096e-013
D4   AXR010   BC1833DV40CTPBFZ 4.50538e-001 2.95250e-009 9.90146e-013
C5   AXR011   BC1833DV40CTPBFZ 2.58059e-001 2.51010e-009 8.40608e-013
C4   AXR012   BC1833DV40CTPBFZ 4.53251e-001 3.15490e-009 8.42999e-013
B3   AXR013   BC1833DV40CTPBFZ 4.94703e-001 4.00220e-009 7.40491e-013
B4   AXR014   BC1833DV40CTPBFZ 6.26064e-001 5.27040e-009 8.70708e-013
A4   AXR015   BC1833DV40CTPBFZ 5.69193e-001 4.65980e-009 7.60530e-013
E2   AXR02   BC1833DV40CTPBFZ 4.58046e-001 4.05840e-009 7.62216e-013
E3   AXR03   BC1833DV40CTPBFZ 6.03822e-001 5.34400e-009 9.04861e-013
D1   AXR04   BC1833DV40CTPBFZ 5.22228e-001 4.82720e-009 7.59112e-013
D3   AXR05   BC1833DV40CTPBFZ 6.17668e-001 5.68500e-009 9.46537e-013
C1   AXR06   BC1833DV40CTPBFZ 5.46060e-001 5.18360e-009 7.72304e-013
D2   AXR07   BC1833DV40CTPBFZ 4.69058e-001 4.07530e-009 8.16364e-013
E4   AXR08   BC1833DV40CTPBFZ 4.33873e-001 2.99390e-009 9.65579e-013
C3   AXR09   BC1833DV40CTPBFZ 4.41997e-001 3.42670e-009 8.54225e-013
C14  EMAA0_GP50   BC1833DV40CTPBFZ 2.98382e-001 2.12110e-009 6.59617e-013
D15  EMAA1_GP51   BC1833DV40CTPBFZ 5.42787e-001 4.38610e-009 7.97764e-013
C12  EMAA10_GP510 BC1833DV40CTPBFZ 2.66169e-001 1.88560e-009 6.21067e-013
B12  EMAA11_GP511 BC1833DV40CTPBFZ 2.63919e-001 2.25010e-009 6.03279e-013
D13  EMAA12_GP512 BC1833DV40CTPBFZ 4.96551e-001 4.38480e-009 8.15026e-013
D11  EMAA13_GP513 BC1833DV40CTPBFZ 4.28105e-001 2.84370e-009 7.34402e-013
A12  EMAA14_GP514 BC1833DV40CTPBFZ 3.52992e-001 3.00810e-009 5.84119e-013
C11  EMAA15_GP515 BC1833DV40CTPBFZ 2.52056e-001 1.79990e-009 6.53107e-013
E12  EMAA16_GP40  BC1833DV40CTPBFZ 5.25507e-001 4.62630e-009 8.90034e-013
B11  EMAA17_GP41  BC1833DV40CTPBFZ 3.48210e-001 2.51590e-009 6.11958e-013
E11  EMAA18_GP42  BC1833DV40CTPBFZ 4.54964e-001 3.32960e-009 8.69791e-013
C10  EMAA19_GP43  BC1833DV40CTPBFZ 3.76906e-001 2.39340e-009 7.09774e-013
B14  EMAA2_GP52   BC1833DV40CTPBFZ 3.90592e-001 2.72300e-009 6.24758e-013
A11  EMAA20_GP44  BC1833DV40CTPBFZ 3.45761e-001 2.96740e-009 6.10012e-013
B10  EMAA21_GP45  BC1833DV40CTPBFZ 2.46960e-001 2.00900e-009 5.42935e-013
A10  EMAA22_GP46  BC1833DV40CTPBFZ 3.33152e-001 2.60470e-009 5.37496e-013
E9   EMAA23_GP47  BC1833DV40CTPBFZ 3.19065e-001 2.29880e-009 7.32743e-013
D14  EMAA3_GP53   BC1833DV40CTPBFZ 4.79376e-001 3.69480e-009 7.71487e-013
A14  EMAA4_GP54   BC1833DV40CTPBFZ 3.97984e-001 3.13500e-009 5.42094e-013
C13  EMAA5_GP55   BC1833DV40CTPBFZ 4.22523e-001 2.74470e-009 6.79880e-013
E13  EMAA6_GP56   BC1833DV40CTPBFZ 3.48995e-001 2.90190e-009 8.13518e-013
B13  EMAA7_GP57   BC1833DV40CTPBFZ 3.66929e-001 2.60810e-009 6.24751e-013
A13  EMAA8_GP58   BC1833DV40CTPBFZ 3.72708e-001 3.04190e-009 5.38465e-013
D12  EMAA9_GP59   BC1833DV40CTPBFZ 3.33588e-001 2.40090e-009 7.00953e-013
C15  EMABA0_GP28  BC1833DV40CTPBFZ 3.18300e-001 2.38740e-009 7.10753e-013
A15  EMABA1_GP29  BC1833DV40CTPBFZ 4.17096e-001 3.30950e-009 5.86538e-013
A9   EMACASn_GP24 BC1833DV40CTPBFZ 3.54881e-001 2.82330e-009 5.65088e-013
B7   EMACLK_GP27  BC1833DV40CTPBFZ 3.56531e-001 2.34950e-009 5.60045e-013
A18  EMACS0n_GP20 BC1833DV40CTPBFZ 3.97081e-001 3.74280e-009 7.21563e-013
B17  EMACS2n_GP315 BC1833DV40CTPBFZ 5.80198e-001 5.09880e-009 8.43227e-013
A17  EMACS3n_GP314 BC1833DV40CTPBFZ 3.78016e-001 3.46170e-009 7.23538e-013
F9   EMACS4n_GP313 BC1833DV40CTPBFZ 5.19550e-001 3.90300e-009 9.18755e-013
B16  EMACS5n_GP212 BC1833DV40CTPBFZ 5.51095e-001 4.76040e-009 7.96121e-013
C9   EMAD0_GP48   BC1833DV40CTPBFZ 2.44304e-001 1.64890e-009 6.18740e-013
A8   EMAD1_GP49   BC1833DV40CTPBFZ 3.32250e-001 2.52330e-009 5.06368e-013
A7   EMAD10_GP32  BC1833DV40CTPBFZ 3.48770e-001 2.64970e-009 5.08237e-013
D6   EMAD11_GP33  BC1833DV40CTPBFZ 2.37569e-001 1.57190e-009 7.49192e-013
A6   EMAD12_GP34  BC1833DV40CTPBFZ 5.66268e-001 4.40960e-009 8.45128e-013
B6   EMAD13_GP35  BC1833DV40CTPBFZ 5.13874e-001 3.70700e-009 7.90354e-013
C7   EMAD14_GP36  BC1833DV40CTPBFZ 5.91744e-001 4.61700e-009 1.00047e-012
E6   EMAD15_GP37  BC1833DV40CTPBFZ 1.98115e-001 1.36540e-009 7.81085e-013
B8   EMAD2_GP410  BC1833DV40CTPBFZ 3.46727e-001 2.30150e-009 5.60570e-013
E8   EMAD3_GP411  BC1833DV40CTPBFZ 4.91407e-001 3.76040e-009 8.64890e-013
B5   EMAD4_GP412  BC1833DV40CTPBFZ 4.54268e-001 3.17380e-009 6.52985e-013
E7   EMAD5_GP413  BC1833DV40CTPBFZ 2.62992e-001 2.12650e-009 1.09788e-012
C6   EMAD6_GP414  BC1833DV40CTPBFZ 5.38100e-001 3.95790e-009 8.47380e-013
D7   EMAD7_GP415  BC1833DV40CTPBFZ 5.81194e-001 4.67290e-009 1.06233e-012
E10  EMAD8_GP30   BC1833DV40CTPBFZ 3.75790e-001 3.17900e-009 8.92133e-013
D9   EMAD9_GP31   BC1833DV40CTPBFZ 4.95004e-001 3.95170e-009 7.99211e-013
B15  EMAOEn_GP310 BC1833DV40CTPBFZ 2.95177e-001 2.25360e-009 5.63438e-013
A16  EMARASn_GP25 BC1833DV40CTPBFZ 4.31087e-001 3.59950e-009 5.83703e-013
D10  EMARNW_GP39  BC1833DV40CTPBFZ 4.67072e-001 3.80790e-009 7.79641e-013
D8   EMASDCKE_GP26 BC1833DV40CTPBFZ 4.66445e-001 3.42630e-009 7.54319e-013
B18  EMAWAIT0_GP38 BC1833DV40CTPBFZ 4.09634e-001 3.45430e-009 7.14985e-013
B19  EMAWAIT1_GP21 BC1833DV40CTPBFZ 4.41357e-001 4.08480e-009 8.09083e-013
B9   EMAWEn_GP311 BC1833DV40CTPBFZ 3.54014e-001 2.53790e-009 5.62877e-013
C8   EMAWEDQM0n_GP23 BC1833DV40CTPBFZ 3.74193e-001 2.37840e-009 6.26113e-013
A5   EMAWEDQM1n_GP22 BC1833DV40CTPBFZ 5.13242e-001 3.94230e-009 6.49289e-013
U7   DDRA0   BSSTL18TCSCGPBFZ 4.14960e-001 2.73750e-009 6.79471e-013
T7   DDRA1   BSSTL18TCSCGPBFZ 4.61192e-001 3.10260e-009 7.39296e-013
W6   DDRA2   BSSTL18TCSCGPBFZ 3.98765e-001 3.02010e-009 5.57871e-013
V6   DDRA3   BSSTL18TCSCGPBFZ 2.72035e-001 2.08680e-009 5.20945e-013
U5   DDRA4   BSSTL18TCSCGPBFZ 4.39992e-001 3.22490e-009 6.44839e-013
V5   DDRA5   BSSTL18TCSCGPBFZ 4.35683e-001 3.07040e-009 5.81074e-013
W5   DDRA6   BSSTL18TCSCGPBFZ 4.21472e-001 3.27020e-009 5.67079e-013
U6   DDRA7   BSSTL18TCSCGPBFZ 2.85462e-001 1.89380e-009 6.46976e-013
U4   DDRA8   BSSTL18TCSCGPBFZ 4.88010e-001 3.63800e-009 7.05605e-013
T6   DDRA9   BSSTL18TCSCGPBFZ 1.92149e-001 1.42270e-009 6.24918e-013
W4   DDRA10   BSSTL18TCSCGPBFZ 4.35328e-001 3.47630e-009 5.60660e-013
T4   DDRA11   BSSTL18TCSCGPBFZ 5.10405e-001 3.72920e-009 8.12116e-013
V4   DDRA12   BSSTL18TCSCGPBFZ 4.38115e-001 3.08480e-009 5.82197e-013
T5   DDRA13   BSSTL18TCSCGPBFZ 2.15693e-001 1.70520e-009 7.47184e-013
V8   DDRBA0   BSSTL18TCSCGPBFZ 4.80522e-001 3.52320e-009 6.92654e-013
T9   DDRBA1   BSSTL18TCSCGPBFZ 2.20318e-001 1.65540e-009 6.83534e-013
U8   DDRBA2   BSSTL18TCSCGPBFZ 4.04014e-001 2.49850e-009 6.68341e-013
U9   DDRCASn   BSSTL18TCSCGPBFZ 3.88058e-001 2.44280e-009 6.26800e-013
V7   DDRCKE   BSSTL18TCSCGPBFZ 2.57587e-001 2.00620e-009 5.46471e-013
W7   DDRCLKN   BSSTL18TCSCGPBFZ 3.64269e-001 2.70550e-009 5.00661e-013
W8   DDRCLKP   BSSTL18TCSCGPBFZ 3.53476e-001 2.69690e-009 5.06199e-013
V9   DDRCSn   BSSTL18TCSCGPBFZ 3.47483e-001 2.33680e-009 5.61910e-013
U15  DDRD0   BSSTL18TCSCGPBFZ 5.03067e-001 4.08480e-009 6.88721e-013
U14  DDRD1   BSSTL18TCSCGPBFZ 4.44055e-001 3.34930e-009 6.99179e-013
V14  DDRD2   BSSTL18TCSCGPBFZ 4.43485e-001 3.67420e-009 6.49287e-013
U13  DDRD3   BSSTL18TCSCGPBFZ 4.23858e-001 3.01220e-009 6.42646e-013
V13  DDRD4   BSSTL18TCSCGPBFZ 2.95715e-001 2.54430e-009 6.14396e-013
V12  DDRD5   BSSTL18TCSCGPBFZ 3.88855e-001 2.74710e-009 5.41742e-013
W12  DDRD6   BSSTL18TCSCGPBFZ 3.67182e-001 2.92840e-009 5.28344e-013
W11  DDRD7   BSSTL18TCSCGPBFZ 2.56622e-001 2.82530e-009 6.12911e-013
T13  DDRD8   BSSTL18TCSCGPBFZ 4.76155e-001 3.51100e-009 8.24674e-013
T11  DDRD9   BSSTL18TCSCGPBFZ 4.46810e-001 3.14220e-009 7.61080e-013
T10  DDRD10   BSSTL18TCSCGPBFZ 3.12174e-001 2.45150e-009 6.81267e-013
T12  DDRD11   BSSTL18TCSCGPBFZ 4.66794e-001 3.38780e-009 8.50234e-013
U10  DDRD12   BSSTL18TCSCGPBFZ 3.86652e-001 2.58760e-009 6.64029e-013
V10  DDRD13   BSSTL18TCSCGPBFZ 3.78944e-001 2.51470e-009 6.06810e-013
U11  DDRD14   BSSTL18TCSCGPBFZ 4.74936e-001 3.29650e-009 8.05328e-013
W10  DDRD15   BSSTL18TCSCGPBFZ 3.79744e-001 3.73260e-009 6.60169e-013
W13  DDRDQM0n   BSSTL18TCSCGPBFZ 3.94835e-001 3.04360e-009 5.62703e-013
R10  DDRDQM1n   BSSTL18TCSCGPBFZ 4.61673e-001 3.54330e-009 8.26589e-013
W9   DDRRASn   BSSTL18TCSCGPBFZ 3.50051e-001 2.72800e-009 5.47279e-013
R11  DDRDQGATE0   BSSTL18TCSCGPBFZ 4.90814e-001 3.50590e-009 8.76801e-013
R12  DDRDQGATE1   BSSTL18TCSCGPBFZ 5.15291e-001 3.70680e-009 9.84983e-013
T8   DDRWEn   BSSTL18TCSCGPBFZ 4.42497e-001 2.97360e-009 6.63102e-013
T14  DDRDQS0   BSSTL18TCSCGPBFZ 4.80092e-001 3.48030e-009 7.80760e-013
V11  DDRDQS1   BSSTL18TCSCGPBFZ 4.22650e-001 3.29520e-009 6.81403e-013
J16  EMU0   BC1833DV40CTPBFZ 2.54325e-001 1.81840e-009 7.85509e-013
K16  EMU1   BC1833DV40CTPBFZ 4.29846e-001 3.27960e-009 8.14633e-013
K4   GP61   BC1833DV40CTPBFZ 3.63614e-001 2.49020e-009 8.31825e-013
J3   GP62   BC1833DV40CTPBFZ 2.73739e-001 2.52640e-009 7.69287e-013
K3   GP63   BC1833DV40CTPBFZ 3.69454e-001 2.75510e-009 7.14832e-013
H3   GP64   BC1833DV40CTPBFZ 5.80089e-001 5.21570e-009 8.91399e-013
F2   GP810   BC1833DV40CTPBFZ 4.49068e-001 3.95750e-009 7.41073e-013
F1   GP811   BC1833DV40CTPBFZ 4.97064e-001 4.59930e-009 7.63107e-013
G3   GP812   BC1833DV40CTPBFZ 4.22225e-001 3.12280e-009 9.06650e-013
J4   GP813   BC1833DV40CTPBFZ 4.18358e-001 2.77620e-009 8.64397e-013
G2   GP814   BC1833DV40CTPBFZ 4.46474e-001 3.75040e-009 7.54261e-013
G1   GP815   BC1833DV40CTPBFZ 4.80067e-001 4.12220e-009 6.81038e-013
G4   GP88   BC1833DV40CTPBFZ 3.97460e-001 2.83360e-009 8.04305e-013
H4   GP89   BC1833DV40CTPBFZ 4.23690e-001 2.97660e-009 8.22397e-013
R5   GP60   BC1833DV40CTPBFZ 2.45883e-001 2.09100e-009 8.01025e-013
W1   GP78   BC1833DV40CTPBFZ 4.78964e-001 4.27560e-009 6.54315e-013
W2   GP79   BC1833DV40CTPBFZ 4.54813e-001 3.82070e-009 6.79498e-013
T2   GP72   BC1833DV40CTPBFZ 4.36957e-001 3.45270e-009 5.91877e-013
T3   GP73   BC1833DV40CTPBFZ 4.16931e-001 3.05630e-009 6.29650e-013
R1   GP74   BC1833DV40CTPBFZ 4.54506e-001 3.65190e-009 6.34173e-013
R2   GP75   BC1833DV40CTPBFZ 4.20647e-001 3.27220e-009 7.29881e-013
R3   GP76   BC1833DV40CTPBFZ 3.26617e-001 2.78190e-009 6.90042e-013
P4   GP77   BC1833DV40CTPBFZ 4.14093e-001 2.81750e-009 7.64469e-013
W3   GP710   BC1833DV40CTPBFZ 2.28452e-002 1.01420e-010 5.62555e-013
V1   GP711   BC1833DV40CTPBFZ 4.77687e-001 4.00580e-009 6.74578e-013
V2   GP712   BC1833DV40CTPBFZ 4.48597e-001 3.75400e-009 6.51164e-013
V3   GP713   BC1833DV40CTPBFZ 4.36018e-001 3.43390e-009 7.00041e-013
U1   GP714   BC1833DV40CTPBFZ 4.80254e-001 3.78490e-009 6.52073e-013
U2   GP715   BC1833DV40CTPBFZ 4.40999e-001 3.40200e-009 6.15258e-013
U3   GP70   BC1833DV40CTPBFZ 4.34081e-001 3.33150e-009 6.89105e-013
T1   GP71   BC1833DV40CTPBFZ 4.87422e-001 3.88830e-009 5.92797e-013
J17  NMIn   IC1833DVTPBFZP18LL 3.65961e-001 2.64340e-009 6.81345e-013
K14  RESETn   IHHV1833DVTP18 3.13948e-001 1.92720e-009 9.39463e-013
K17  GP80   BC1833DV40CTPBFZ 4.98560e-001 4.09850e-009 7.97021e-013
D19  EPWM0A   BC1833DV40CTPBFZ 5.47450e-001 4.73470e-009 7.69394e-013
C17  EPWM0B   BC1833DV40CTPBFZ 2.77268e-001 2.63370e-009 7.30178e-013
D17  GP16   BC1833DV40CTPBFZ 4.00877e-001 2.84850e-009 6.63256e-013
E16  GP17   BC1833DV40CTPBFZ 1.85753e-001 1.58290e-009 7.38386e-013
D16  GP81   BC1833DV40CTPBFZ 2.94303e-001 2.04320e-009 6.93329e-013
E17  GP82   BC1833DV40CTPBFZ 4.47987e-001 3.34480e-009 7.84496e-013
D18  GP83   BC1833DV40CTPBFZ 4.37452e-001 3.53960e-009 6.89681e-013
C19  GP84   BC1833DV40CTPBFZ 4.72581e-001 3.82440e-009 6.65189e-013
C18  GP85   BC1833DV40CTPBFZ 4.70155e-001 3.77380e-009 6.89104e-013
C16  GP86   BC1833DV40CTPBFZ 2.76089e-001 2.46530e-009 7.57539e-013
G19  SPI1CLK_GP213 BC1833DV40CTPBFZ 4.69262e-001 4.17240e-009 7.11445e-013
H16  SPI1ENAn_GP212 BC1833DV40CTPBFZ 2.65537e-001 2.13550e-009 7.16472e-013
E19  SPI1SCS0n   BC1833DV40CTPBFZ 4.90496e-001 4.15100e-009 7.37763e-013
F18  SPI1SCS1n   BC1833DV40CTPBFZ 4.59876e-001 3.78990e-009 7.28257e-013
F19  SPI1SCS2n   BC1833DV40CTPBFZ 4.93949e-001 4.19790e-009 7.59046e-013
E18  SPI1SCS3n   BC1833DV40CTPBFZ 3.81442e-001 3.01750e-009 6.17218e-013
F16  SPI1SCS4n   BC1833DV40CTPBFZ 3.91821e-001 2.59160e-009 7.64737e-013
F17  SPI1SCS5n   BC1833DV40CTPBFZ 3.81978e-001 2.67900e-009 6.57715e-013
G18  SPI1SCS6n   BC1833DV40CTPBFZ 4.07238e-001 3.79210e-009 7.95139e-013
G16  SPI1SCS7n   BC1833DV40CTPBFZ 2.69265e-001 1.90170e-009 7.00785e-013
G17  SPI1SIMO_GP210 BC1833DV40CTPBFZ 3.72117e-001 2.60560e-009 6.80138e-013
H17  SPI1SOMI_GP211 BC1833DV40CTPBFZ 4.56903e-001 3.42860e-009 7.28034e-013
J15  TCK   IC1833DVTPBFZP18LL 2.57521e-001 1.72010e-009 7.51806e-013
M16  TDI   IC1833DVTPBFZP18LL 5.58912e-001 5.27220e-009 1.06666e-012
J18  TDO   BC1833DV40CTPBFZ 3.51274e-001 2.87560e-009 6.76444e-013
L16  TMS   IC1833DVTPBFZP18LL 3.99407e-001 2.92060e-009 8.37004e-013
L17  TRSTn   IC1833DVTPBFZP18LL 3.86978e-001 3.09900e-009 7.62159e-013
T17  UHPIHASn   BC1833DV40CTPBFZ 3.86492e-001 2.71460e-009 7.41946e-013
U17  UHPIHCNTL0   BC1833DV40CTPBFZ 2.42945e-002 8.15850e-011 8.17122e-013
W15  UHPIHCNTL1   BC1833DV40CTPBFZ 4.27573e-001 3.54430e-009 5.42549e-013
W14  UHPIHCSn   BC1833DV40CTPBFZ 3.48379e-001 3.02510e-009 5.61183e-013
P17  UHPIHD0   BC1833DV40CTPBFZ 5.04430e-001 4.02180e-009 9.65050e-013
R15  UHPIHD1   BC1833DV40CTPBFZ 4.61967e-001 3.22070e-009 9.22461e-013
W17  UHPIHD10   BC1833DV40CTPBFZ 5.06372e-001 4.43790e-009 6.29295e-013
V17  UHPIHD11   BC1833DV40CTPBFZ 5.14141e-001 4.40180e-009 6.46147e-013
W16  UHPIHD12   BC1833DV40CTPBFZ 4.47674e-001 3.61480e-009 5.80945e-013
R14  UHPIHD13   BC1833DV40CTPBFZ 2.29936e-001 1.93580e-009 9.83864e-013
V16  UHPIHD14   BC1833DV40CTPBFZ 4.88188e-001 3.91970e-009 6.17589e-013
U18  UHPIHD15   BC1833DV40CTPBFZ 5.62311e-001 4.83050e-009 8.64648e-013
R19  UHPIHD2   BC1833DV40CTPBFZ 5.16823e-001 4.57930e-009 7.51770e-013
R18  UHPIHD3   BC1833DV40CTPBFZ 5.00110e-001 4.15440e-009 7.75793e-013
T16  UHPIHD4   BC1833DV40CTPBFZ 2.66853e-001 2.25470e-009 8.85923e-013
U19  UHPIHD5   BC1833DV40CTPBFZ 5.90890e-001 5.06810e-009 8.95998e-013
V19  UHPIHD6   BC1833DV40CTPBFZ 5.79160e-001 4.93500e-009 7.59523e-013
V18  UHPIHD7   BC1833DV40CTPBFZ 5.37053e-001 4.49240e-009 8.46758e-013
W19  UHPIHD8   BC1833DV40CTPBFZ 5.52593e-001 5.15440e-009 7.41144e-013
W18  UHPIHD9   BC1833DV40CTPBFZ 5.25636e-001 4.65020e-009 7.16361e-013
V15  UHPIHDS1n   BC1833DV40CTPBFZ 3.19300e-001 2.53200e-009 7.20635e-013
T18  UHPIHDS2n   BC1833DV40CTPBFZ 3.90741e-001 3.11240e-009 6.27607e-013
U16  UHPIHHWIL   BC1833DV40CTPBFZ 5.17218e-001 4.36310e-009 7.63222e-013
R16  UHPIHINTn   BC1833DV40CTPBFZ 4.10882e-001 2.49400e-009 7.51548e-013
R17  UHPIHRDYn   BC1833DV40CTPBFZ 3.95791e-001 2.69860e-009 8.08520e-013
T15  UHPIHRWn   BC1833DV40CTPBFZ 3.77610e-001 2.93410e-009 7.45095e-013
K18  USB0DRVVBUS  BC1833DV40CTPBFZ 3.81954e-001 3.14290e-009 6.88529e-013
[Model Selector] IHHV1833DVTP18
|  This seciton is used to determine the IBIS model to use depending
|  on which voltage is supplied to the Dual Voltage I/O Buffers
HV1833DVTP18_7LM_1P8   Dual Voltage I/O Buffer with 1.8V External Supply
HV1833DVTP18_7LM_3P3   Dual Voltage I/O Buffer with 3.3V External Supply
[Model Selector] IC1833DVTPBFZP18LL
|  This seciton is used to determine which IBIS Model is to be used
|  for the pins depending on the functionality required by the user's
|  application.
BFZP18LL_!PI_LOW_1P8  Cell operated at 1.8(nom)
|IC1833DVTPBFZP18LL_!PI_LOW_1P8;
|BUFFER WITH WEAK_PULLDOWN_ON NOMINAL CURRENT OF 100UA WHEN PAD=VDDS
FZP18LL_!PI_HIGH_1P8  Cell operated at 1.8(nom)
|IC1833DVTPBFZP18LL_!PI_HIGH_1P8;
|BUFFER WITH WEAK_PULLUP_ON NOMINAL CURRENT OF 100UA WHEN PAD=0
3DVTPBFZP18LL_PI_1P8  Cell operated at 1.8(nom)
|IC1833DVTPBFZP18LL_PI_1P8;
|BUFFER IN NORMAL MODE WITH PULLUP AND PULLDOWN OFF
BFZP18LL_!PI_LOW_3P3  Cell operated at 3.3(nom)
|IC1833DVTPBFZP18LL_!PI_LOW_3P3;
|BUFFER WITH WEAK_PULLDOWN_ON NOMINAL CURRENT OF 100UA WHEN PAD=VDDS
FZP18LL_!PI_HIGH_3P3  Cell operated at 3.3(nom)
|IC1833DVTPBFZP18LL_!PI_HIGH_3P3;
|BUFFER WITH WEAK_PULLUP_ON NOMINAL CURRENT OF 100UA WHEN PAD=0
3DVTPBFZP18LL_PI_3P3  Cell operated at 3.3(nom)
|IC1833DVTPBFZP18LL_PI_3P3;
|BUFFER IN NORMAL MODE WITH PULLUP AND PULLDOWN OFF
[Model Selector] BC1833DV40CTPBFZ
|  This seciton is used to determine the IBIS model to use depending
|  on which voltage is supplied to the Dual Voltage I/O Buffers
18LL_X50_!PI_LOW_1P8  Cell operated at 1.8(nom)
|BC1833DV40CTPBFZ_!PI_LOW_1P8;
|BUFFER WITH WEAK_PULLDOWN_ON NOMINAL CURRENT OF 100UA WHEN PAD=VDDS
8LL_X50_!PI_HIGH_1P8  Cell operated at 1.8(nom)
|BC1833DV40CTPBFZ_!PI_HIGH_1P8;
|BUFFER WITH WEAK_PULLUP_ON NOMINAL CURRENT OF 100UA WHEN PAD=0
PBFZP18LL_X50_PI_1P8  Cell operated at 1.8(nom)
|BC1833DV40CTPBFZ_PI_1P8;
|BUFFER IN NORMAL MODE WITH PULLUP AND PULLDOWN OFF
18LL_X50_!PI_LOW_3P3  Cell operated at 3.3(nom)
|BC1833DV40CTPBFZ_!PI_LOW_3P3;
|BUFFER WITH WEAK_PULLDOWN_ON NOMINAL CURRENT OF 100UA WHEN PAD=VDDS
8LL_X50_!PI_HIGH_3P3  Cell operated at 3.3(nom)
|BC1833DV40CTPBFZ_!PI_HIGH_3P3;
|BUFFER WITH WEAK_PULLUP_ON NOMINAL CURRENT OF 100UA WHEN PAD=0
PBFZP18LL_X50_PI_3P3  Cell operated at 3.3(nom)
|BC1833DV40CTPBFZ_PI_3P3;
|BUFFER IN NORMAL MODE WITH PULLUP AND PULLDOWN OFF
[Model Selector] BSSTL18TCSCGPBFZ
NOSR0_NOTERM_1P8  Cell operated at 1.8(nom)
|NOSR0_NOTERM_1P8
|BUFFER OPERATING AT FAST MODE WITH 1.8V SUPPLY WITH +/-10% VARIATION
NOSR0_NOTERM_0.1_1P8  Cell operated at 1.8(nom)
| Models and submodels in the file (16): HV1833DVTP18_7LM_1P8 (Input), HV1833DVTP18_7LM_3P3 (Input), BFZP18LL_!PI_LOW_1P8 (Input), FZP18LL_!PI_HIGH_1P8 (Input), 3DVTPBFZP18LL_PI_1P8 (Input), BFZP18LL_!PI_LOW_3P3 (Input), FZP18LL_!PI_HIGH_3P3 (Input), 3DVTPBFZP18LL_PI_3P3 (Input), NOSR0_NOTERM_1P8 (3-state), NOSR0_NOTERM_0.1_1P8 (3-state), 18LL_X50_!PI_LOW_1P8 (I/O), 8LL_X50_!PI_HIGH_1P8 (I/O), PBFZP18LL_X50_PI_1P8 (I/O), 18LL_X50_!PI_LOW_3P3 (I/O), 8LL_X50_!PI_HIGH_3P3 (I/O), PBFZP18LL_X50_PI_3P3 (I/O)
