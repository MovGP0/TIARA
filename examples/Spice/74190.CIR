Created by TINA
*************************************
**  This file was created by TINA  **
**    (c) 1996 DesignSoft, Inc.    **
*************************************
.LIB "TSPICE.LIB" ; for the examples only
* Please use your own Spice libraries.
.TEMP 27
.TRAN 40U 20M

.PROBE D(4) D(6) D(7) D(8) D(9)

UNoname     INV $G_DPWR $G_DGND    3  21  U_SN7404 IO_STD
UNoname_2   NOR(2) $G_DPWR $G_DGND    3   3  22  U_SN7402 IO_STD
UNoname_3   NOR(2) $G_DPWR $G_DGND    3  21  23  U_SN7402 IO_STD
UNoname_4   AND(3) $G_DPWR $G_DGND   21  13  19  24  U_SN7411 IO_STD
UNoname_5   AND(5) $G_DPWR $G_DGND    3  14  16  18  20  25  U_SN7408 IO_STD
UNoname_6   NAND(2) $G_DPWR $G_DGND    3  12  26  U_SN7400 IO_STD
UNoname_7   NAND(2) $G_DPWR $G_DGND   26  12  27  U_SN7400 IO_STD
UNoname_8   NAND(2) $G_DPWR $G_DGND    3  12  28  U_SN7400 IO_STD
UNoname_9   NAND(3) $G_DPWR $G_DGND   16  18  20  29  U_SN7410 IO_STD
UNoname_10  NAND(2) $G_DPWR $G_DGND   28  12  30  U_SN7400 IO_STD
UNoname_11  NAND(2) $G_DPWR $G_DGND    3  12  31  U_SN7400 IO_STD
UNoname_12  NAND(2) $G_DPWR $G_DGND   31  12  32  U_SN7400 IO_STD
UNoname_13  NAND(2) $G_DPWR $G_DGND    3  12  33  U_SN7400 IO_STD
UNoname_14  NAND(2) $G_DPWR $G_DGND   33  12  34  U_SN7400 IO_STD
UNoname_15  AND(3) $G_DPWR $G_DGND   23  14  29  35  U_SN7411 IO_STD
UNoname_16  AND(3) $G_DPWR $G_DGND   13  20  22  36  U_SN7411 IO_STD
UNoname_17  AND(4) $G_DPWR $G_DGND   29  23  14  16  37  U_4082 IO_STD
UNoname_18  AND(3) $G_DPWR $G_DGND   13  15  22  38  U_SN7411 IO_STD
UNoname_19  AND(4) $G_DPWR $G_DGND   23  14  16  18  39  U_4082 IO_STD
UNoname_20  AND(3) $G_DPWR $G_DGND   13  19  22  40  U_SN7411 IO_STD
UNoname_21  AND(4) $G_DPWR $G_DGND   13  15  17  22  41  U_4082 IO_STD
UNoname_22  INV $G_DPWR $G_DGND    3  42  U_SN7404 IO_STD
UNoname_23  OR(2) $G_DPWR $G_DGND   35  36  43  U_SN7432 IO_STD
UNoname_24  OR(2) $G_DPWR $G_DGND   37  38  44  U_SN7432 IO_STD
UNoname_25  OR(3) $G_DPWR $G_DGND   39  40  41  45  U_4075 IO_STD
UNoname_26  INV $G_DPWR $G_DGND    4  10  U_SN7404_1 IO_STD
UNoname_27  INV $G_DPWR $G_DGND    3  11  U_SN7404_2 IO_STD
UNoname_28  INV $G_DPWR $G_DGND    5  12  U_SN7404_3 IO_STD
UNoname_29  JKFF(1) $G_DPWR $G_DGND
+        26  27   4  42  42  13  14  U_SN74107_1 IO_STD
UNoname_30  JKFF(1) $G_DPWR $G_DGND
+        28  30   4  43  43  15  16  U_SN74107_2 IO_STD
UNoname_31  JKFF(1) $G_DPWR $G_DGND
+        31  32   4  44  44  17  18  U_SN74107_3 IO_STD
UNoname_32  JKFF(1) $G_DPWR $G_DGND
+        33  34   4  45  45  19  20  U_SN74107_4 IO_STD
UNoname_33  OR(2) $G_DPWR $G_DGND   24  25   2  U_SN7432_1 IO_STD
UNoname_34  NAND(3) $G_DPWR $G_DGND   10  11   2   1  U_SN7410_1 IO_STD
UNoname_35  BUF $G_DPWR $G_DGND   13   6  U_SN7407_1 IO_STD_OC
UNoname_36  BUF $G_DPWR $G_DGND   15   7  U_SN7407_2 IO_STD_OC
UNoname_37  BUF $G_DPWR $G_DGND   17   8  U_SN7407_3 IO_STD_OC
UNoname_38  BUF $G_DPWR $G_DGND   19   9  U_SN7407_4 IO_STD_OC
UCLK        STIM(1,1) $G_DPWR $G_DGND 4 IO_STM
+      0 1
+      LABEL = STARTLOOP
+      6.2M 0
+      6.7M 1
+      7.2M GOTO STARTLOOP -1 TIMES
UL          STIM(1,1) $G_DPWR $G_DGND 3 IO_STM
+      0 0
ULOAD       STIM(1,1) $G_DPWR $G_DGND 5 IO_STM
+      0 1
+      6M 0
+      7M 1

.MODEL U_SN7404 UGATE( TPLHTY=22N TPHLTY=15N )
.MODEL U_SN7402 UGATE( TPLHTY=22N TPHLTY=15N )
.MODEL U_SN7411 UGATE( TPLHTY=27N TPHLTY=19N )
.MODEL U_SN7408 UGATE( TPLHTY=27N TPHLTY=19N )
.MODEL U_SN7400 UGATE( TPLHTY=22N TPHLTY=15N )
.MODEL U_SN7410 UGATE( TPLHTY=22N TPHLTY=15N )
.MODEL U_4082 UGATE( TPLHTY=210N TPHLTY=210N )
.MODEL U_SN7432 UGATE( TPLHTY=15N TPHLTY=22N )
.MODEL U_4075 UGATE( TPLHTY=210N TPHLTY=210N )
.MODEL U_SN74107 UEFF( TPPCQLHTY=25N TPCLKQLHTY=25N TPPCQHLTY=40N TPCLKQHLTY=40N )
.MODEL U_SN7407 UGATE( TPLHTY=10N )
.MODEL U_SN7404_1 AKO: U_SN7404 UGATE( TPLHTY=22N TPHLTY=15N )
.MODEL U_SN7404_2 AKO: U_SN7404 UGATE( TPLHTY=22N TPHLTY=15N )
.MODEL U_SN7404_3 AKO: U_SN7404 UGATE( TPLHTY=22N TPHLTY=15N )
.MODEL U_SN74107_1 AKO: U_SN74107 UEFF( TPPCQLHTY=25N TPPCQHLTY=40N )
.MODEL U_SN74107_2 AKO: U_SN74107 UEFF( TPPCQLHTY=25N TPPCQHLTY=40N )
.MODEL U_SN74107_3 AKO: U_SN74107 UEFF( TPPCQLHTY=25N TPPCQHLTY=40N )
.MODEL U_SN74107_4 AKO: U_SN74107 UEFF( TPPCQLHTY=25N TPPCQHLTY=40N )
.MODEL U_SN7432_1 AKO: U_SN7432 UGATE( TPLHTY=15N TPHLTY=22N )
.MODEL U_SN7410_1 AKO: U_SN7410 UGATE( TPLHTY=22N TPHLTY=15N )
.MODEL U_SN7407_1 AKO: U_SN7407 UGATE( TPLHTY=10N )
.MODEL U_SN7407_2 AKO: U_SN7407 UGATE( TPLHTY=10N )
.MODEL U_SN7407_3 AKO: U_SN7407 UGATE( TPLHTY=10N )
.MODEL U_SN7407_4 AKO: U_SN7407 UGATE( TPLHTY=10N )

.END
